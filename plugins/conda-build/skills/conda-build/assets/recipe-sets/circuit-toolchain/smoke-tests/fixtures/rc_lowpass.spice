* RC Low-pass Filter - ngspice smoke testing
.title RC Low-pass Filter

V1 in 0 PULSE(0 1 0 1n 1n 5u 10u)
R1 in out 1k
C1 out 0 1n

.tran 10n 20u
.control
run
wrdata rc_lowpass_out.txt v(out)
quit
.endc

.end
