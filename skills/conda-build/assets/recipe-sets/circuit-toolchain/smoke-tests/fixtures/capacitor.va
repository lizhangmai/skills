`include "disciplines.vams"

module capacitor(p, n);
    inout p, n;
    electrical p, n;
    parameter real c = 1e-12 from (0:inf);

    analog begin
        I(p, n) <+ ddt(c * V(p, n));
    end
endmodule
